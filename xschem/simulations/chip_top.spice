** sch_path: /foss/designs/adex_neuron/ttihp26a-adex-neuron-ncs/xschem/chip_top.sch
**.subckt chip_top ui_in[7],ui_in[6],ui_in[5],ui_in[4],ui_in[3],ui_in[2],ui_in[1],ui_in[0] ua[5],ua[4],ua[3],ua[2],ua[1],ua[0]
*+ VDPWR uo_out[7],uo_out[6],uo_out[5],uo_out[4],uo_out[3],uo_out[2],uo_out[1],uo_out[0] VGND
*+ uio_in[7],uio_in[6],uio_in[5],uio_in[4],uio_in[3],uio_in[2],uio_in[1],uio_in[0] uio_out[7],uio_out[6],uio_out[5],uio_out[4],uio_out[3],uio_out[2],uio_out[1],uio_out[0]
*+ uio_oe[7],uio_oe[6],uio_oe[5],uio_oe[4],uio_oe[3],uio_oe[2],uio_oe[1],uio_oe[0]
*.iopin VDPWR
*.iopin VGND
*.ipin ui_in[7],ui_in[6],ui_in[5],ui_in[4],ui_in[3],ui_in[2],ui_in[1],ui_in[0]
*.opin uo_out[7],uo_out[6],uo_out[5],uo_out[4],uo_out[3],uo_out[2],uo_out[1],uo_out[0]
*.ipin uio_in[7],uio_in[6],uio_in[5],uio_in[4],uio_in[3],uio_in[2],uio_in[1],uio_in[0]
*.opin uio_out[7],uio_out[6],uio_out[5],uio_out[4],uio_out[3],uio_out[2],uio_out[1],uio_out[0]
*.opin uio_oe[7],uio_oe[6],uio_oe[5],uio_oe[4],uio_oe[3],uio_oe[2],uio_oe[1],uio_oe[0]
*.iopin ua[5],ua[4],ua[3],ua[2],ua[1],ua[0]
xrow[10] VDPWR VGND VDPWR VGND ua[4] ua[5] NN_mem_VNT[10] ua[3] ua[2] uio_out[7] ua[1] NN_refcap_VT[10] uio_in[4] neuron_row
xrow[9] VDPWR VGND VDPWR VGND ua[4] ua[5] NN_mem_VNT[9] ua[3] ua[2] uio_out[6] ua[1] NN_refcap_VT[9] uio_in[3] neuron_row
xrow[8] VDPWR VGND VDPWR VGND ua[4] ua[5] NN_mem_VNT[8] ua[3] ua[2] uio_out[5] ua[1] NN_refcap_VT[8] uio_in[2] neuron_row
xrow[7] VDPWR VGND VDPWR VGND ua[4] ua[5] NN_mem_VNT[7] ua[3] ua[2] uo_out[7] ua[1] NN_refcap_VT[7] ui_in[7] neuron_row
xrow[6] VDPWR VGND VDPWR VGND ua[4] ua[5] NN_mem_VNT[6] ua[3] ua[2] uo_out[6] ua[1] NN_refcap_VT[6] ui_in[6] neuron_row
xrow[5] VDPWR VGND VDPWR VGND ua[4] ua[5] NN_mem_VNT[5] ua[3] ua[2] uo_out[5] ua[1] NN_refcap_VT[5] ui_in[5] neuron_row
xrow[4] VDPWR VGND VDPWR VGND ua[4] ua[5] NN_mem_VNT[4] ua[3] ua[2] uo_out[4] ua[1] NN_refcap_VT[4] ui_in[4] neuron_row
xrow[3] VDPWR VGND VDPWR VGND ua[4] ua[5] NN_mem_VNT[3] ua[3] ua[2] uo_out[3] ua[1] NN_refcap_VT[3] ui_in[3] neuron_row
xrow[2] VDPWR VGND VDPWR VGND ua[4] ua[5] NN_mem_VNT[2] ua[3] ua[2] uo_out[2] ua[1] NN_refcap_VT[2] ui_in[2] neuron_row
xrow[1] VDPWR VGND VDPWR VGND ua[4] ua[5] NN_mem_VNT[1] ua[3] ua[2] uo_out[1] ua[1] NN_refcap_VT[1] ui_in[1] neuron_row
xrow[0] VDPWR VGND VDPWR VGND ua[4] ua[5] NN_mem_VNT[0] ua[3] ua[2] uo_out[0] ua[1] NN_refcap_VT[0] ui_in[0] neuron_row
xabuf[1] NN_refcap_VT[0] VDPWR ua[4] buf2mux_VTX1[1] VGND VDPWR VGND analog_buffer
xabuf[0] NN_mem_VNT[0] VDPWR ua[4] buf2mux_VTX1[0] VGND VDPWR VGND analog_buffer
xmux VDPWR VGND buf2mux_VTX1[0] buf2mux_VTX1[1] uio_in[0] uio_in[1] ua[0] mux21
xoehi[2] VDPWR VGND uio_oe[7] sg13g2_tiehi
xoehi[1] VDPWR VGND uio_oe[6] sg13g2_tiehi
xoehi[0] VDPWR VGND uio_oe[5] sg13g2_tiehi
xoelo[4] VDPWR VGND uio_oe[4] sg13g2_tielo
xoelo[3] VDPWR VGND uio_oe[3] sg13g2_tielo
xoelo[2] VDPWR VGND uio_oe[2] sg13g2_tielo
xoelo[1] VDPWR VGND uio_oe[1] sg13g2_tielo
xoelo[0] VDPWR VGND uio_oe[0] sg13g2_tielo
xoelo1[4] VDPWR VGND uio_out[4] sg13g2_tielo
xoelo1[3] VDPWR VGND uio_out[3] sg13g2_tielo
xoelo1[2] VDPWR VGND uio_out[2] sg13g2_tielo
xoelo1[1] VDPWR VGND uio_out[1] sg13g2_tielo
xoelo1[0] VDPWR VGND uio_out[0] sg13g2_tielo
* noconn uio_in[7:5]
* noconn NN_mem_VNT[10:1]
* noconn NN_refcap_VT[10:1]
XCadecap[3] VGND ua[4] cap_cmim w=75e-6 l=75e-6
XCadecap[2] VGND ua[3] cap_cmim w=75e-6 l=75e-6
XCadecap[1] VGND ua[2] cap_cmim w=75e-6 l=75e-6
XCadecap[0] VGND ua[1] cap_cmim w=75e-6 l=75e-6
XCdecap2[4] VGND VDPWR cap_cmim w=75e-6 l=75e-6
XCdecap2[3] VGND VDPWR cap_cmim w=75e-6 l=75e-6
XCdecap2[2] VGND VDPWR cap_cmim w=75e-6 l=75e-6
XCdecap2[1] VGND VDPWR cap_cmim w=75e-6 l=75e-6
XCdecap2[0] VGND VDPWR cap_cmim w=75e-6 l=75e-6
XCdecap1[2] VGND VDPWR cap_cmim w=30e-6 l=75e-6
XCdecap1[1] VGND VDPWR cap_cmim w=30e-6 l=75e-6
XCdecap1[0] VGND VDPWR cap_cmim w=30e-6 l=75e-6
XCdecap3[2] VGND VDPWR cap_cmim w=75e-6 l=34e-6
XCdecap3[1] VGND VDPWR cap_cmim w=75e-6 l=34e-6
XCdecap3[0] VGND VDPWR cap_cmim w=75e-6 l=34e-6
XCdecap4 VGND VDPWR cap_cmim w=30e-6 l=34e-6
**.ends

* expanding   symbol:  neuron_row.sym # of pins=13
** sym_path: /foss/designs/adex_neuron/ttihp26a-adex-neuron-ncs/xschem/neuron_row.sym
** sch_path: /foss/designs/adex_neuron/ttihp26a-adex-neuron-ncs/xschem/neuron_row.sch
.subckt neuron_row VDD GND nwell psub bias_VPI in_VI mem_VNTO cm_VI tau_VNI req_VABO ref_VNI refcap_VTO ack_VABI
*.ipin in_VI
*.ipin cm_VI
*.ipin bias_VPI
*.iopin VDD
*.iopin GND
*.iopin nwell
*.iopin psub
*.opin mem_VNTO
*.opin req_VABO
*.opin refcap_VTO
*.ipin tau_VNI
*.ipin ref_VNI
*.ipin ack_VABI
Xneuron VDD I_in tau_VNI mem_VNTO req_VABO ack_VABI ref_VNI GND refcap_VTO psub nwell neuron_noahp
xv2i VDD bias_VPI cm_VI in_VI I_in GND nwell psub V2I
.ends

* expanding   symbol:  analog_buffer.sym # of pins=7
** sym_path: /foss/designs/adex_neuron/ttihp26a-adex-neuron-ncs/xschem/analog_buffer.sym
** sch_path: /foss/designs/adex_neuron/ttihp26a-adex-neuron-ncs/xschem/analog_buffer.sch
.subckt analog_buffer inp_cm VDD Vbias out GND nwell psub
*.ipin inp_cm
*.opin out
*.iopin VDD
*.iopin GND
*.ipin Vbias
*.iopin psub
*.iopin nwell
XM2 Vm inp_cm Vb nwell sg13_hv_pmos w=4u l=1u ng=1 m=4
XM5 Vm Vm GND psub sg13_hv_nmos w=4u l=1u ng=1 m=4
XM13 Vb Vbias VDD nwell sg13_hv_pmos w=4u l=1u ng=1 m=40
XM3 out out Vb nwell sg13_hv_pmos w=4u l=1u ng=1 m=4
XM1 out Vm GND psub sg13_hv_nmos w=4u l=1u ng=1 m=4
XMDBIAS VDD VDD VDD nwell sg13_hv_pmos w=4u l=1u ng=2 m=20
XMDdiffINP Vb Vb Vb nwell sg13_hv_pmos w=4u l=1u ng=2 m=2
XMDdiffINN Vb Vb Vb nwell sg13_hv_pmos w=4u l=1u ng=2 m=2
XMDNMIRA GND GND GND psub sg13_hv_nmos w=4u l=1u ng=2 m=2
XMDNMIRB GND GND GND psub sg13_hv_nmos w=4u l=1u ng=2 m=2
.ends

* expanding   symbol:  mux21.sym # of pins=7
** sym_path: /foss/designs/adex_neuron/ttihp26a-adex-neuron-ncs/xschem/mux21.sym
** sch_path: /foss/designs/adex_neuron/ttihp26a-adex-neuron-ncs/xschem/mux21.sch
.subckt mux21 VDD VSS IN0 IN1 SEL0 SEL1 OUT
*.iopin VDD
*.iopin VSS
*.ipin IN0
*.ipin IN1
*.ipin SEL0
*.ipin SEL1
*.opin OUT
x1 VDD VSS SEL0 OUT IN0 tg_lv
x2 VDD VSS SEL1 OUT IN1 tg_lv
.ends

* expanding   symbol:  sg13g2_tiehi.sym # of pins=3
** sym_path: /foss/designs/adex_neuron/ttihp26a-adex-neuron-ncs/xschem/sg13g2_tiehi.sym
** sch_path: /foss/designs/adex_neuron/ttihp26a-adex-neuron-ncs/xschem/sg13g2_tiehi.sch
.subckt sg13g2_tiehi VDD VSS L_HI
*.iopin VSS
*.iopin VDD
*.opin L_HI
XMN1 net1 net1 VSS VSS sg13_lv_nmos w=0.3u l=0.13u ng=1
XMP1 net2 net1 VDD VDD sg13_lv_pmos w=0.66u l=0.13u ng=1
XMN2 net3 net2 VSS VSS sg13_lv_nmos w=0.795u l=0.13u ng=1
XMP2 L_HI net3 VDD VDD sg13_lv_pmos w=1.155u l=0.13u ng=1
.ends

* expanding   symbol:  sg13g2_tielo.sym # of pins=3
** sym_path: /foss/designs/adex_neuron/ttihp26a-adex-neuron-ncs/xschem/sg13g2_tielo.sym
** sch_path: /foss/designs/adex_neuron/ttihp26a-adex-neuron-ncs/xschem/sg13g2_tielo.sch
.subckt sg13g2_tielo VDD VSS L_LO
*.iopin VSS
*.iopin VDD
*.opin L_LO
XMN1 net3 net2 VSS VSS sg13_lv_nmos w=0.385u l=0.13u ng=1
XMP1 net2 net2 VDD VDD sg13_lv_pmos w=0.3u l=0.13u ng=1
XMN2 L_LO net1 VSS VSS sg13_lv_nmos w=0.88u l=0.13u ng=1
XMP2 net1 net3 VDD VDD sg13_lv_pmos w=1.045u l=0.13u ng=1
.ends

* expanding   symbol:  neuron_noahp.sym # of pins=11
** sym_path: /foss/designs/adex_neuron/ttihp26a-adex-neuron-ncs/xschem/neuron_noahp.sym
** sch_path: /foss/designs/adex_neuron/ttihp26a-adex-neuron-ncs/xschem/neuron_noahp.sch
.subckt neuron_noahp VDD I_in V_lk Vmem REQ ACK V_ref GND Vrefcap psub nwell
*.ipin V_ref
*.iopin GND
*.iopin VDD
*.opin REQ
*.ipin ACK
*.ipin I_in
*.ipin V_lk
*.opin Vmem
*.opin Vrefcap
*.iopin psub
*.iopin nwell
Xinv1 VDD nwell net1 Vfb psub GND inv
Xinv2 VDD nwell REQ net1 psub GND inv
Xdpi1 I_in VDD Vmem V_lk GND nwell psub DPI
Xfb VDD Vfb Vmem GND nwell psub FB_system
Xref ACK Vmem REQ Vrefcap GND V_ref VDD nwell psub REF_system
XCmem GND Vmem cap_cmim w=44.4e-6 l=15e-6
XCref GND Vrefcap cap_cmim w=22.1e-6 l=15e-6
.ends

* expanding   symbol:  V2I.sym # of pins=8
** sym_path: /foss/designs/adex_neuron/ttihp26a-adex-neuron-ncs/xschem/V2I.sym
** sch_path: /foss/designs/adex_neuron/ttihp26a-adex-neuron-ncs/xschem/V2I.sch
.subckt V2I VDD Vbias inn_cm inp_cm out GND nwell psub
*.ipin inn_cm
*.ipin inp_cm
*.opin out
*.ipin Vbias
*.iopin VDD
*.iopin GND
*.iopin psub
*.iopin nwell
XMIRA Vm Vm GND psub sg13_hv_nmos w=4u l=1u ng=2 m=4
XMBIAS Vb Vbias VDD nwell sg13_hv_pmos w=4u l=1u ng=2 m=4
XMIRB out Vm GND psub sg13_hv_nmos w=4u l=1u ng=2 m=4
XMdiffINN out inn_cm Vb nwell sg13_hv_pmos w=4u l=1u ng=2 m=4
XMDBIAS VDD VDD VDD nwell sg13_hv_pmos w=4u l=1u ng=2 m=2
XMIDC out Vbias VDD nwell sg13_hv_pmos w=3u l=1u ng=2 m=4
XMDIDC VDD VDD VDD nwell sg13_hv_pmos w=3u l=1u ng=2 m=2
XMdiffINP Vm inp_cm Vb nwell sg13_hv_pmos w=4u l=1u ng=2 m=4
XMDdiffINP Vb Vb Vb nwell sg13_hv_pmos w=4u l=1u ng=2 m=2
XMDdiffINN Vb Vb Vb nwell sg13_hv_pmos w=4u l=1u ng=2 m=2
XMDNMIRA GND GND GND psub sg13_hv_nmos w=4u l=1u ng=2 m=2
XMDNMIRB GND GND GND psub sg13_hv_nmos w=4u l=1u ng=2 m=2
.ends

* expanding   symbol:  tg_lv.sym # of pins=5
** sym_path: /foss/designs/adex_neuron/ttihp26a-adex-neuron-ncs/xschem/tg_lv.sym
** sch_path: /foss/designs/adex_neuron/ttihp26a-adex-neuron-ncs/xschem/tg_lv.sch
.subckt tg_lv VDD VSS SEL OUT IN
*.ipin IN
*.iopin VDD
*.iopin VSS
*.iopin OUT
*.ipin SEL
x1 VDD SEL selbar VSS inv_lv
XM3 IN SEL OUT VSS sg13_lv_nmos w=8u l=0.15u ng=8
XM4 IN selbar OUT VDD sg13_lv_pmos w=8u l=0.15u ng=8
XMdumm1 VDD VDD VDD VDD sg13_lv_pmos w=1u l=0.15u ng=1 m=2
XMdumm2 VSS VSS VSS VSS sg13_lv_nmos w=1u l=0.15u ng=1 m=2
.ends

* expanding   symbol:  inv.sym # of pins=6
** sym_path: /foss/designs/adex_neuron/ttihp26a-adex-neuron-ncs/xschem/inv.sym
** sch_path: /foss/designs/adex_neuron/ttihp26a-adex-neuron-ncs/xschem/inv.sch
.subckt inv VDD nwell out in psub GND
*.ipin in
*.iopin GND
*.opin out
*.iopin VDD
*.iopin nwell
*.iopin psub
XM1 out in VDD nwell sg13_hv_pmos w=4u l=0.5u ng=1
XM2 out in GND psub sg13_hv_nmos w=4u l=0.5u ng=1
.ends

* expanding   symbol:  DPI.sym # of pins=7
** sym_path: /foss/designs/adex_neuron/ttihp26a-adex-neuron-ncs/xschem/DPI.sym
** sch_path: /foss/designs/adex_neuron/ttihp26a-adex-neuron-ncs/xschem/DPI.sch
.subckt DPI I_in VDD V_mem V_lk GND nwell psub
*.opin V_mem
*.ipin V_lk
*.ipin I_in
*.iopin VDD
*.iopin GND
*.iopin nwell
*.iopin psub
XMdifl GND V_lk I_in nwell sg13_hv_pmos w=2u l=2u ng=2 m=8
XMdifr V_mem V_mem I_in nwell sg13_hv_pmos w=2u l=2u ng=2 m=8
XMtau V_mem V_lk GND psub sg13_hv_nmos w=4u l=4u ng=2 m=4
XMdum1 VDD VDD VDD nwell sg13_hv_pmos w=5u l=2u ng=10 m=2
XMdum2 I_in VDD VDD nwell sg13_hv_pmos w=1u l=2u ng=1 m=8
XMdum3 GND GND GND psub sg13_hv_nmos w=2u l=4u ng=4 m=2
XMdum4 GND GND GND psub sg13_hv_nmos w=0.5u l=3u ng=1 m=4
XMdum5 GND GND GND psub sg13_hv_nmos w=2u l=3u ng=1 m=4
.ends

* expanding   symbol:  FB_system.sym # of pins=6
** sym_path: /foss/designs/adex_neuron/ttihp26a-adex-neuron-ncs/xschem/FB_system.sym
** sch_path: /foss/designs/adex_neuron/ttihp26a-adex-neuron-ncs/xschem/FB_system.sch
.subckt FB_system VDD out V_mem GND nwell psub
*.opin out
*.iopin V_mem
*.iopin VDD
*.iopin GND
*.iopin nwell
*.iopin psub
XMmirr Vmir Vmir VDD nwell sg13_hv_pmos w=4u l=2u ng=4
XMmirl4 V_mem Vmir net1 nwell sg13_hv_pmos w=1u l=2u ng=1
XMthr out V_mem Vmir nwell sg13_hv_pmos w=4u l=2u ng=4
XMmem1 out V_mem net2 psub sg13_hv_nmos w=1u l=2u ng=1 m=2
XMmirl3 net1 Vmir net3 nwell sg13_hv_pmos w=1u l=2u ng=1
XMmirl2 net3 Vmir net4 nwell sg13_hv_pmos w=1u l=2u ng=1
XMmirl1 net4 Vmir VDD nwell sg13_hv_pmos w=1u l=2u ng=1
XMmem2 net2 V_mem net5 psub sg13_hv_nmos w=1u l=2u ng=1 m=2
XMmem3 net5 V_mem net6 psub sg13_hv_nmos w=1u l=2u ng=1 m=2
XMmem4 net6 V_mem GND psub sg13_hv_nmos w=1u l=2u ng=1 m=2
XMdum1 GND GND GND psub sg13_hv_nmos w=6u l=2u ng=6 m=2
XMdum2 GND GND GND psub sg13_hv_nmos w=1u l=2u ng=1 m=2
XMdum3 out GND GND psub sg13_hv_nmos w=1u l=2u ng=1 m=2
XMdum4 VDD VDD VDD nwell sg13_hv_pmos w=6u l=2u ng=6 m=2
XMdum5 VDD VDD VDD nwell sg13_hv_pmos w=1u l=2u ng=1 m=3
XMdum6 out VDD VDD nwell sg13_hv_pmos w=1u l=2u ng=1 m=2
XMdum7 V_mem VDD VDD nwell sg13_hv_pmos w=1u l=2u ng=1
.ends

* expanding   symbol:  REF_system.sym # of pins=9
** sym_path: /foss/designs/adex_neuron/ttihp26a-adex-neuron-ncs/xschem/REF_system.sym
** sch_path: /foss/designs/adex_neuron/ttihp26a-adex-neuron-ncs/xschem/REF_system.sch
.subckt REF_system ACK V_mem REQ Vrefcap GND V_ref VDD nwell psub
*.iopin VDD
*.iopin GND
*.ipin V_ref
*.ipin REQ
*.ipin ACK
*.ipin V_mem
*.opin Vrefcap
*.iopin psub
*.iopin nwell
XM10 Vrefcap REQ net2 nwell sg13_hv_pmos w=1u l=0.5u ng=1
XM11 Vrefcap REQ net1 psub sg13_hv_nmos w=1u l=0.5u ng=1
XM12 net2 ACK VDD nwell sg13_hv_pmos w=1u l=0.5u ng=1
XM13 V_mem Vrefcap GND psub sg13_hv_nmos w=1u l=0.5u ng=1
XM14 net1 V_ref GND psub sg13_hv_nmos w=4u l=4u ng=2 m=4
XMdum3 GND GND GND psub sg13_hv_nmos w=2u l=4u ng=4 m=2
XMdum4 GND GND GND psub sg13_hv_nmos w=0.5u l=3u ng=1 m=4
XMdum5 GND GND GND psub sg13_hv_nmos w=2u l=3u ng=1 m=4
.ends

* expanding   symbol:  inv_lv.sym # of pins=4
** sym_path: /foss/designs/adex_neuron/ttihp26a-adex-neuron-ncs/xschem/inv_lv.sym
** sch_path: /foss/designs/adex_neuron/ttihp26a-adex-neuron-ncs/xschem/inv_lv.sch
.subckt inv_lv VDD in out VSS
*.ipin in
*.opin out
*.iopin VDD
*.iopin VSS
XM3 out in VDD VDD sg13_lv_pmos w=1u l=0.15u ng=1
XM4 out in VSS VSS sg13_lv_nmos w=1u l=0.15u ng=1
XMdumm1 VDD VDD VDD VDD sg13_lv_pmos w=1u l=0.15u ng=1 m=2
XMdumm2 VSS VSS VSS VSS sg13_lv_nmos w=1u l=0.15u ng=1 m=2
.ends

.end
