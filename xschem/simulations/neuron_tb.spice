** sch_path: /foss/designs/adex_neuron/ttihp26a-adex-neuron-ncs/xschem/neuron_tb.sch
**.subckt neuron_tb
Xneuron VDD I_in I_thr I_lk vmem REQ I_adapt I_thrahp CapAdap ACK I_lkahp Iref GND neuron
Ithr VDD I_thr 16p
Ilk VDD I_lk 4p
Ispkthr I_adapt GND 4n
Iin VDD I_in dc 0 ac 0 pulse(0 1n 100u 20n 20n 5m 5m)
VDD1 VDD net1 1.2
Iref VDD Iref 1n
Vidd net1 GND 0
.save i(vidd)
Ilkahp VDD I_lkahp 100p
Ithrahp VDD I_thrahp 40p
XM26 I_thr I_thr GND GND sg13_hv_nmos w=4u l=4u ng=1 m=4
XM27 I_lk I_lk GND GND sg13_hv_nmos w=4u l=5u ng=1 m=4
XM15 Iref Iref GND GND sg13_hv_nmos w=4u l=4u ng=1 m=4
XM22 I_adapt I_adapt VDD VDD sg13_hv_pmos w=4u l=4u ng=1 m=4
XM31 I_thrahp I_thrahp GND GND sg13_hv_nmos w=4u l=4u ng=1 m=4
XM32 I_lkahp I_lkahp GND GND sg13_hv_nmos w=4u l=5u ng=1 m=4
Xinv3 VDD REQ net2 GND inv
Xinv4 VDD net2 ACK GND inv
C1 I_thr GND 1p
C2 I_lk GND 1p
C3 Iref GND 1p
C4 I_adapt GND 1p
C5 I_thrahp GND 1p
C6 I_lkahp GND 1p
**** begin user architecture code

.param temp=27

.ic V(xneuron.vmem)=0 V(xneuron.xref.vref)=0 V(REQ)=0 V(ACK)=0 V(xneuron.xadap.CapAdapt)=0

.options gmin=1e-13
.control

save V(ACK) V(REQ) V(vmem) V(xneuron.xref.vref) V(CapAdap)
save V(xneuron.xfb.vmir) V(xneuron.xfb.vd) I(xneuron.xfb.vfb) V(xneuron.vfb)

tran 50n 10m
write neuron_tb.raw
.endc

.lib cornerMOSlv.lib mos_tt
.lib cornerMOShv.lib mos_tt

**** end user architecture code
**.ends

* expanding   symbol:  neuron.sym # of pins=13
** sym_path: /foss/designs/adex_neuron/ttihp26a-adex-neuron-ncs/xschem/neuron.sym
** sch_path: /foss/designs/adex_neuron/ttihp26a-adex-neuron-ncs/xschem/neuron.sch
.subckt neuron VDD I_in V_th V_lk Vmem REQ V_adapt V_thrahp CapAdap ACK V_lkahp V_ref GND
*.ipin V_ref
*.iopin GND
*.iopin VDD
*.opin REQ
*.ipin ACK
*.ipin I_in
*.ipin V_th
*.ipin V_lk
*.ipin V_adapt
*.ipin V_thrahp
*.ipin V_lkahp
*.opin CapAdap
*.opin Vmem
Xinv1 VDD Vfb net1 GND inv
Xinv2 VDD net1 REQ GND inv
Xdpi1 I_in VDD V_th Vmem V_lk GND DPI
Xfb VDD Vfb Vmem GND FB_system
Xadap VDD REQ CapAdap V_adapt I_in V_thrahp V_lkahp GND ADAP_system
Xref VDD ACK Vmem REQ V_ref GND REF_system
Cmem Vmem GND 1p
.ends

* expanding   symbol:  inv.sym # of pins=4
** sym_path: /foss/designs/adex_neuron/ttihp26a-adex-neuron-ncs/xschem/inv.sym
** sch_path: /foss/designs/adex_neuron/ttihp26a-adex-neuron-ncs/xschem/inv.sch
.subckt inv VDD in out GND
*.ipin in
*.iopin VDD
*.iopin GND
*.opin out
XM1 out in VDD VDD sg13_hv_pmos w=1u l=0.5u ng=1
XM2 out in GND GND sg13_hv_nmos w=1u l=0.5u ng=1
.ends

* expanding   symbol:  DPI.sym # of pins=6
** sym_path: /foss/designs/adex_neuron/ttihp26a-adex-neuron-ncs/xschem/DPI.sym
** sch_path: /foss/designs/adex_neuron/ttihp26a-adex-neuron-ncs/xschem/DPI.sch
.subckt DPI I_in VDD V_th V_mem V_lk GND
*.opin V_mem
*.ipin V_lk
*.ipin V_th
*.ipin I_in
*.iopin VDD
*.iopin GND
XMdifl GND V_th I_in VDD sg13_hv_pmos w=4u l=8u ng=4 m=4
XMdifr V_mem V_mem I_in VDD sg13_hv_pmos w=4u l=8u ng=4 m=4
XMtau V_mem V_lk GND GND sg13_hv_nmos w=4u l=10u ng=2 m=4
.ends

* expanding   symbol:  FB_system.sym # of pins=4
** sym_path: /foss/designs/adex_neuron/ttihp26a-adex-neuron-ncs/xschem/FB_system.sym
** sch_path: /foss/designs/adex_neuron/ttihp26a-adex-neuron-ncs/xschem/FB_system.sch
.subckt FB_system VDD out V_mem GND
*.opin out
*.iopin V_mem
*.iopin VDD
*.iopin GND
XM1 out V_mem GND GND sg13_hv_nmos w=4u l=4u ng=2 m=4
XM3 Vmir Vmir VDD VDD sg13_hv_pmos w=4u l=4u ng=4 m=2
XM20 V_mem out Vd VDD sg13_hv_pmos w=4u l=0.5u ng=2 m=4
XM2 Vd Vmir net1 net1 sg13_hv_pmos w=4u l=4u ng=4 m=4
XM23 out V_mem Vmir VDD sg13_hv_pmos w=8u l=4u ng=2 m=4
Vfb VDD net1 0
.save i(vfb)
.ends

* expanding   symbol:  ADAP_system.sym # of pins=8
** sym_path: /foss/designs/adex_neuron/ttihp26a-adex-neuron-ncs/xschem/ADAP_system.sym
** sch_path: /foss/designs/adex_neuron/ttihp26a-adex-neuron-ncs/xschem/ADAP_system.sch
.subckt ADAP_system VDD REQ CapAdap V_adapt I_in V_thrahp V_lkahp GND
*.iopin VDD
*.iopin GND
*.ipin REQ
*.ipin V_adapt
*.ipin V_thrahp
*.ipin V_lkahp
*.ipin I_in
*.opin CapAdap
XM19 net2 REQ VDD VDD sg13_hv_pmos w=1u l=0.5u ng=1
XM21 net1 V_adapt net2 VDD sg13_hv_pmos w=4u l=4u ng=2 m=4
XM18 I_in CapAdap GND GND sg13_hv_nmos w=4u l=4u ng=2 m=4
Cmem2 CapAdap GND 2p
Xdpi2 net1 VDD V_thrahp CapAdap V_lkahp GND DPI
.ends

* expanding   symbol:  REF_system.sym # of pins=6
** sym_path: /foss/designs/adex_neuron/ttihp26a-adex-neuron-ncs/xschem/REF_system.sym
** sch_path: /foss/designs/adex_neuron/ttihp26a-adex-neuron-ncs/xschem/REF_system.sch
.subckt REF_system VDD ACK V_mem REQ V_ref GND
*.iopin VDD
*.iopin GND
*.ipin V_ref
*.ipin REQ
*.ipin ACK
*.ipin V_mem
Cr Vref GND 0.5p
XM10 Vref REQ net2 VDD sg13_hv_pmos w=1u l=0.5u ng=1
XM11 Vref REQ net1 GND sg13_hv_nmos w=1u l=0.5u ng=1
XM12 net2 ACK VDD VDD sg13_hv_pmos w=1u l=0.5u ng=1
XM13 V_mem Vref GND GND sg13_hv_nmos w=1u l=0.5u ng=1
XM14 net1 V_ref GND GND sg13_hv_nmos w=4u l=4u ng=2 m=4
.ends

.GLOBAL GND
.GLOBAL VDD
.end
