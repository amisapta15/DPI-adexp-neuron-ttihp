** sch_path: /foss/designs/adex_neuron/ttihp26a-adex-neuron-ncs/xschem/FB_system.sch
**.subckt FB_system VDD out V_mem GND
*.opin out
*.iopin V_mem
*.iopin VDD
*.iopin GND
XMmirr Vmir Vmir VDD nwell sg13_hv_pmos w=4u l=2u ng=4
XMmirl4 V_mem Vmir net1 nwell sg13_hv_pmos w=1u l=2u ng=1
XMthr out V_mem Vmir nwell sg13_hv_pmos w=4u l=2u ng=4
XMmem1 out V_mem net2 psub sg13_hv_nmos w=1u l=2u ng=1 m=2
XMmirl3 net1 Vmir net3 nwell sg13_hv_pmos w=1u l=2u ng=1
XMmirl2 net3 Vmir net4 nwell sg13_hv_pmos w=1u l=2u ng=1
XMmirl1 net4 Vmir VDD nwell sg13_hv_pmos w=1u l=2u ng=1
XMmem2 net2 V_mem net5 psub sg13_hv_nmos w=1u l=2u ng=1 m=2
XMmem3 net5 V_mem net6 psub sg13_hv_nmos w=1u l=2u ng=1 m=2
XMmem4 net6 V_mem GND psub sg13_hv_nmos w=1u l=2u ng=1 m=2
XMdum1 GND GND GND psub sg13_hv_nmos w=6u l=2u ng=6 m=2
XMdum2 GND GND GND psub sg13_hv_nmos w=1u l=2u ng=1 m=2
XMdum3 out GND GND psub sg13_hv_nmos w=1u l=2u ng=1 m=2
XMdum4 VDD VDD VDD nwell sg13_hv_pmos w=6u l=2u ng=6 m=2
XMdum5 VDD VDD VDD nwell sg13_hv_pmos w=1u l=2u ng=1 m=3
XMdum6 out VDD VDD nwell sg13_hv_pmos w=1u l=2u ng=1 m=2
XMdum7 V_mem VDD VDD nwell sg13_hv_pmos w=1u l=2u ng=1
XR1 VDD nwell ntap1 R=4.4 w=16e-6 l=10.5e-6 rw=0.3e-6
XR2 GND psub ptap1 R=4.829 w=16e-6 l=8.2e-6 rw=0.3e-6
**.ends
.end
