** sch_path: /foss/designs/DPI-adexp-neuron-ttihp/xschem/ncs-dpi-adexp/xschem-ncs/neuron_tb.sch
**.subckt neuron_tb
Xneuron VDD I_in I_thr I_lk vmem REQ I_adapt I_thrahp CapAdap ACK I_lkahp Iref GND neuron
Ithr VDD I_thr 16p
Ilk VDD I_lk 4p
Ispkthr I_adapt GND 4n
Iin VDD I_in dc 0 ac 0 pulse(0 1n 100u 20n 20n 5m 5m)
VDD1 VDD net1 1.2
Iref VDD Iref 1n
Vidd net1 GND 0
.save i(vidd)
Ilkahp VDD I_lkahp 100p
Ithrahp VDD I_thrahp 40p
XM26 I_thr I_thr GND GND sg13_hv_nmos w=4u l=4u ng=1 m=4
XM27 I_lk I_lk GND GND sg13_hv_nmos w=4u l=5u ng=1 m=4
XM15 Iref Iref GND GND sg13_hv_nmos w=4u l=4u ng=1 m=4
XM22 I_adapt I_adapt VDD VDD sg13_hv_pmos w=4u l=4u ng=1 m=4
XM31 I_thrahp I_thrahp GND GND sg13_hv_nmos w=4u l=4u ng=1 m=4
XM32 I_lkahp I_lkahp GND GND sg13_hv_nmos w=4u l=5u ng=1 m=4
Xinv3 net3 net4 REQ net5 inv
Xinv4 net6 net7 net2 net8 inv
C1 I_thr GND 1p
C2 I_lk GND 1p
C3 Iref GND 1p
C4 I_adapt GND 1p
C5 I_thrahp GND 1p
C6 I_lkahp GND 1p
**** begin user architecture code

.param temp=27

.ic V(xneuron.vmem)=0 V(xneuron.xref.vref)=0 V(REQ)=0 V(ACK)=0 V(xneuron.xadap.CapAdapt)=0

.options gmin=1e-13
.control

save V(ACK) V(REQ) V(vmem) V(xneuron.xref.vref) V(CapAdap)
save V(xneuron.xfb.vmir) V(xneuron.xfb.vd) I(xneuron.xfb.vfb) V(xneuron.vfb)

tran 50n 10m
write neuron_tb.raw
.endc

.lib cornerMOSlv.lib mos_tt
.lib cornerMOShv.lib mos_tt

**** end user architecture code
**.ends

* expanding   symbol:  neuron.sym # of pins=13
** sym_path: /foss/designs/DPI-adexp-neuron-ttihp/xschem/ncs-dpi-adexp/xschem-ncs/neuron.sym
** sch_path: /foss/designs/DPI-adexp-neuron-ttihp/xschem/ncs-dpi-adexp/xschem-ncs/neuron.sch
.subckt neuron VDD I_in V_th V_lk Vmem REQ V_adapt V_thrahp CapAdap ACK V_lkahp V_ref GND
*.ipin V_ref
*.iopin GND
*.iopin VDD
*.opin REQ
*.ipin ACK
*.ipin I_in
*.ipin V_th
*.ipin V_lk
*.ipin V_adapt
*.ipin V_thrahp
*.ipin V_lkahp
*.opin CapAdap
*.opin Vmem
Xinv1 net2 net3 Vfb net4 inv
Xinv2 net5 net6 net1 net7 inv
Xdpi1 I_in VDD Vmem V_lk GND DPI
Xfb VDD net8 Vmem GND FB_system
Xadap VDD REQ CapAdap V_adapt I_in V_thrahp V_lkahp GND ADAP_system
Xref ACK Vmem REQ V_ref net9 net10 VDD REF_system
Cmem Vmem GND 1p
.ends

* expanding   symbol:  inv.sym # of pins=4
** sym_path: /foss/designs/DPI-adexp-neuron-ttihp/xschem/ncs-dpi-adexp/xschem-ncs/inv.sym
** sch_path: /foss/designs/DPI-adexp-neuron-ttihp/xschem/ncs-dpi-adexp/xschem-ncs/inv.sch
.subckt inv VDD out in GND
*.ipin in
*.iopin GND
*.opin out
*.iopin VDD
XM1 out in VDD VDD sg13_hv_pmos w=4u l=0.5u ng=1
XM2 out in GND GND sg13_hv_nmos w=4u l=0.5u ng=1
.ends

* expanding   symbol:  DPI.sym # of pins=5
** sym_path: /foss/designs/DPI-adexp-neuron-ttihp/xschem/ncs-dpi-adexp/xschem-ncs/DPI.sym
** sch_path: /foss/designs/DPI-adexp-neuron-ttihp/xschem/ncs-dpi-adexp/xschem-ncs/DPI.sch
.subckt DPI I_in VDD V_mem V_lk GND
*.opin V_mem
*.ipin V_lk
*.ipin I_in
*.iopin VDD
*.iopin GND
XMdifl GND V_lk I_in VDD sg13_hv_pmos w=2u l=2u ng=2 m=8
XMdifr V_mem V_mem I_in VDD sg13_hv_pmos w=2u l=2u ng=2 m=8
XMtau V_mem V_lk GND GND sg13_hv_nmos w=4u l=4u ng=2 m=4
XMdum1 VDD VDD VDD VDD sg13_hv_pmos w=5u l=2u ng=10 m=2
XMdum2 I_in VDD VDD VDD sg13_hv_pmos w=1u l=2u ng=1 m=8
XMdum3 GND GND GND GND sg13_hv_nmos w=2u l=4u ng=4 m=2
XMdum4 GND GND GND GND sg13_hv_nmos w=0.5u l=3u ng=1 m=4
XMdum5 GND GND GND GND sg13_hv_nmos w=2u l=3u ng=1 m=4
.ends

* expanding   symbol:  FB_system.sym # of pins=4
** sym_path: /foss/designs/DPI-adexp-neuron-ttihp/xschem/ncs-dpi-adexp/xschem-ncs/FB_system.sym
** sch_path: /foss/designs/DPI-adexp-neuron-ttihp/xschem/ncs-dpi-adexp/xschem-ncs/FB_system.sch
.subckt FB_system VDD out V_mem GND
*.opin out
*.iopin V_mem
*.iopin VDD
*.iopin GND
XMmirr Vmir Vmir VDD VDD sg13_hv_pmos w=4u l=2u ng=4
XMmirl4 V_mem Vmir net1 VDD sg13_hv_pmos w=1u l=2u ng=1
XMthr out V_mem Vmir VDD sg13_hv_pmos w=4u l=2u ng=4
XMmem1 out V_mem net2 GND sg13_hv_nmos w=1u l=2u ng=1 m=2
XMmirl3 net1 Vmir net3 VDD sg13_hv_pmos w=1u l=2u ng=1
XMmirl2 net3 Vmir net4 VDD sg13_hv_pmos w=1u l=2u ng=1
XMmirl1 net4 Vmir VDD VDD sg13_hv_pmos w=1u l=2u ng=1
XMmem2 net2 V_mem net5 GND sg13_hv_nmos w=1u l=2u ng=1 m=2
XMmem3 net5 V_mem net6 GND sg13_hv_nmos w=1u l=2u ng=1 m=2
XMmem4 net6 V_mem GND GND sg13_hv_nmos w=1u l=2u ng=1 m=2
XMdum1 GND GND GND GND sg13_hv_nmos w=6u l=2u ng=6 m=2
XMdum2 GND GND GND GND sg13_hv_nmos w=1u l=2u ng=1 m=2
XMdum3 out GND GND GND sg13_hv_nmos w=1u l=2u ng=1 m=2
XMdum4 VDD VDD VDD VDD sg13_hv_pmos w=6u l=2u ng=6 m=2
XMdum5 VDD VDD VDD VDD sg13_hv_pmos w=1u l=2u ng=1 m=3
XMdum6 out VDD VDD VDD sg13_hv_pmos w=1u l=2u ng=1 m=2
XMdum7 V_mem VDD VDD VDD sg13_hv_pmos w=1u l=2u ng=1
.ends

* expanding   symbol:  ADAP_system.sym # of pins=8
** sym_path: /foss/designs/DPI-adexp-neuron-ttihp/xschem/ncs-dpi-adexp/xschem-ncs/ADAP_system.sym
** sch_path: /foss/designs/DPI-adexp-neuron-ttihp/xschem/ncs-dpi-adexp/xschem-ncs/ADAP_system.sch
.subckt ADAP_system VDD REQ CapAdap V_adapt I_in V_thrahp V_lkahp GND
*.iopin VDD
*.iopin GND
*.ipin REQ
*.ipin V_adapt
*.ipin V_thrahp
*.ipin V_lkahp
*.ipin I_in
*.opin CapAdap
XM19 net2 REQ VDD VDD sg13_hv_pmos w=1u l=0.5u ng=1
XM21 net1 V_adapt net2 VDD sg13_hv_pmos w=4u l=4u ng=2 m=4
XM18 I_in CapAdap GND GND sg13_hv_nmos w=4u l=4u ng=2 m=4
Cmem2 CapAdap GND 2p
Xdpi2 net1 VDD CapAdap V_lkahp GND DPI
.ends

* expanding   symbol:  REF_system.sym # of pins=7
** sym_path: /foss/designs/DPI-adexp-neuron-ttihp/xschem/ncs-dpi-adexp/xschem-ncs/REF_system.sym
** sch_path: /foss/designs/DPI-adexp-neuron-ttihp/xschem/ncs-dpi-adexp/xschem-ncs/REF_system.sch
.subckt REF_system ACK V_mem REQ Vrefcap GND V_ref VDD
*.iopin VDD
*.iopin GND
*.ipin V_ref
*.ipin REQ
*.ipin ACK
*.ipin V_mem
*.opin Vrefcap
XM10 Vrefcap REQ net2 VDD sg13_hv_pmos w=1u l=0.5u ng=1
XM11 Vrefcap REQ net1 GND sg13_hv_nmos w=1u l=0.5u ng=1
XM12 net2 ACK VDD VDD sg13_hv_pmos w=1u l=0.5u ng=1
XM13 V_mem Vrefcap GND GND sg13_hv_nmos w=1u l=0.5u ng=1
XM14 net1 V_ref GND GND sg13_hv_nmos w=4u l=4u ng=2 m=4
XMdum3 GND GND GND GND sg13_hv_nmos w=2u l=4u ng=4 m=2
XMdum4 GND GND GND GND sg13_hv_nmos w=0.5u l=3u ng=1 m=4
XMdum5 GND GND GND GND sg13_hv_nmos w=2u l=3u ng=1 m=4
.ends

.GLOBAL GND
.GLOBAL VDD
.end
