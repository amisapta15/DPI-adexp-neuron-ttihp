* Extracted by KLayout with SG13G2 LVS runset on : 20/03/2026 17:06

.SUBCKT DPI GND V_mem V_lk VDD I_in
M$1 GND GND GND GND sg13_hv_nmos L=3u W=10u AS=2.65p AD=2.65p PS=19.24u
+ PD=19.24u
M$2 GND GND GND GND sg13_hv_nmos L=4u W=4u AS=0.76p AD=0.76p PS=7.04u PD=7.04u
M$8 GND V_lk V_mem GND sg13_hv_nmos L=4u W=16u AS=3.04p AD=3.04p PS=19.04u
+ PD=19.04u
M$25 VDD VDD VDD VDD sg13_hv_pmos L=2u W=10u AS=2.05p AD=2.05p PS=19.2u PD=19.2u
M$35 VDD VDD I_in VDD sg13_hv_pmos L=2u W=8u AS=2.12p AD=2.12p PS=16.24u
+ PD=16.24u
M$36 I_in V_lk GND VDD sg13_hv_pmos L=2u W=16u AS=3.04p AD=3.04p PS=22.08u
+ PD=22.08u
M$38 I_in V_mem V_mem VDD sg13_hv_pmos L=2u W=16u AS=3.04p AD=3.04p PS=22.08u
+ PD=22.08u
.ENDS DPI
