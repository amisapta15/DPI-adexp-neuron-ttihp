** sch_path: /foss/designs/adex_neuron/chenxi_working/ttihp26a-adex-neuron-ncs/xschem/neuron_noahp.sch
.subckt neuron_noahp VDD I_in V_lk Vmem REQ ACK V_ref GND Vrefcap psub nwell
*.PININFO V_ref:I GND:B VDD:B REQ:O ACK:I I_in:I V_lk:I Vmem:O Vrefcap:O psub:B nwell:B
Xinv1 VDD nwell net1 Vfb psub GND inv
Xinv2 VDD nwell REQ net1 psub GND inv
Xdpi1 I_in VDD Vmem V_lk GND nwell psub DPI
Xfb VDD Vfb Vmem GND nwell psub FB_system
Xref ACK Vmem REQ Vrefcap GND V_ref VDD nwell psub REF_system
Cmem GND Vmem cap_cmim w=44.4e-6 l=15e-6
Cref GND Vrefcap cap_cmim w=22.1e-6 l=15e-6
.ends

* expanding   symbol:  inv.sym # of pins=6
** sym_path: /foss/designs/adex_neuron/chenxi_working/ttihp26a-adex-neuron-ncs/xschem/inv.sym
** sch_path: /foss/designs/adex_neuron/chenxi_working/ttihp26a-adex-neuron-ncs/xschem/inv.sch
.subckt inv VDD nwell out in psub GND
*.PININFO in:I GND:B out:O VDD:B nwell:B psub:B
M1 out in VDD nwell sg13_hv_pmos w=4u l=0.5u ng=1
M2 out in GND psub sg13_hv_nmos w=4u l=0.5u ng=1
R1 GND psub ptap1 A=2e-12 P=6e-06
R2 VDD nwell ntap1 A=2e-12 P=6e-06
.ends

* expanding   symbol:  DPI.sym # of pins=7
** sym_path: /foss/designs/adex_neuron/chenxi_working/ttihp26a-adex-neuron-ncs/xschem/DPI.sym
** sch_path: /foss/designs/adex_neuron/chenxi_working/ttihp26a-adex-neuron-ncs/xschem/DPI.sch
.subckt DPI I_in VDD V_mem V_lk GND nwell psub
*.PININFO V_mem:O V_lk:I I_in:I VDD:B GND:B nwell:B psub:B
Mdifl GND V_lk I_in nwell sg13_hv_pmos w=2u l=2u ng=2 m=8
Mdifr V_mem V_mem I_in nwell sg13_hv_pmos w=2u l=2u ng=2 m=8
Mtau V_mem V_lk GND psub sg13_hv_nmos w=4u l=4u ng=2 m=4
R1 VDD nwell ntap1 A=7.56e-12 P=5.1e-05
R2 VDD nwell ntap1 A=2.7e-12 P=1.86e-05
R3 VDD nwell ntap1 A=2.7e-12 P=1.86e-05
R4 GND psub ptap1 A=2.046e-11 P=0.0001364
Mdum1 VDD VDD VDD nwell sg13_hv_pmos w=5u l=2u ng=10 m=2
Mdum2 I_in VDD VDD nwell sg13_hv_pmos w=1u l=2u ng=1 m=8
Mdum3 GND GND GND psub sg13_hv_nmos w=2u l=4u ng=4 m=2
Mdum4 GND GND GND psub sg13_hv_nmos w=0.5u l=3u ng=1 m=4
Mdum5 GND GND GND psub sg13_hv_nmos w=2u l=3u ng=1 m=4
.ends

* expanding   symbol:  FB_system.sym # of pins=6
** sym_path: /foss/designs/adex_neuron/chenxi_working/ttihp26a-adex-neuron-ncs/xschem/FB_system.sym
** sch_path: /foss/designs/adex_neuron/chenxi_working/ttihp26a-adex-neuron-ncs/xschem/FB_system.sch
.subckt FB_system VDD out V_mem GND nwell psub
*.PININFO out:O V_mem:B VDD:B GND:B nwell:B psub:B
Mmirr Vmir Vmir VDD nwell sg13_hv_pmos w=4u l=2u ng=4
Mmirl4 V_mem Vmir net1 nwell sg13_hv_pmos w=1u l=2u ng=1
Mthr out V_mem Vmir nwell sg13_hv_pmos w=4u l=2u ng=4
Mmem1 out V_mem net2 psub sg13_hv_nmos w=1u l=2u ng=1 m=2
Mmirl3 net1 Vmir net3 nwell sg13_hv_pmos w=1u l=2u ng=1
Mmirl2 net3 Vmir net4 nwell sg13_hv_pmos w=1u l=2u ng=1
Mmirl1 net4 Vmir VDD nwell sg13_hv_pmos w=1u l=2u ng=1
Mmem2 net2 V_mem net5 psub sg13_hv_nmos w=1u l=2u ng=1 m=2
Mmem3 net5 V_mem net6 psub sg13_hv_nmos w=1u l=2u ng=1 m=2
Mmem4 net6 V_mem GND psub sg13_hv_nmos w=1u l=2u ng=1 m=2
Mdum1 GND GND GND psub sg13_hv_nmos w=6u l=2u ng=6 m=2
Mdum2 GND GND GND psub sg13_hv_nmos w=1u l=2u ng=1 m=2
Mdum3 out GND GND psub sg13_hv_nmos w=1u l=2u ng=1 m=2
Mdum4 VDD VDD VDD nwell sg13_hv_pmos w=6u l=2u ng=6 m=2
Mdum5 VDD VDD VDD nwell sg13_hv_pmos w=1u l=2u ng=1 m=3
Mdum6 out VDD VDD nwell sg13_hv_pmos w=1u l=2u ng=1 m=2
Mdum7 V_mem VDD VDD nwell sg13_hv_pmos w=1u l=2u ng=1
R1 VDD nwell ntap1 A=1.554e-11 P=0.0001036
R2 GND psub ptap1 A=1.416e-11 P=9.44e-05
.ends

* expanding   symbol:  REF_system.sym # of pins=9
** sym_path: /foss/designs/adex_neuron/chenxi_working/ttihp26a-adex-neuron-ncs/xschem/REF_system.sym
** sch_path: /foss/designs/adex_neuron/chenxi_working/ttihp26a-adex-neuron-ncs/xschem/REF_system.sch
.subckt REF_system ACK V_mem REQ Vrefcap GND V_ref VDD nwell psub
*.PININFO VDD:B GND:B V_ref:I REQ:I ACK:I V_mem:I Vrefcap:O psub:B nwell:B
M10 Vrefcap REQ net2 nwell sg13_hv_pmos w=1u l=0.5u ng=1
M11 Vrefcap REQ net1 psub sg13_hv_nmos w=1u l=0.5u ng=1
M12 net2 ACK VDD nwell sg13_hv_pmos w=1u l=0.5u ng=1
M13 V_mem Vrefcap GND psub sg13_hv_nmos w=1u l=0.5u ng=1
M14 net1 V_ref GND psub sg13_hv_nmos w=4u l=4u ng=2 m=4
Mdum3 GND GND GND psub sg13_hv_nmos w=2u l=4u ng=4 m=2
Mdum4 GND GND GND psub sg13_hv_nmos w=0.5u l=3u ng=1 m=4
Mdum5 GND GND GND psub sg13_hv_nmos w=2u l=3u ng=1 m=4
R4 GND psub ptap1 A=2.046e-11 P=0.0001364
R1 VDD nwell ntap1 A=1.824e-11 P=0.0001216
.ends
