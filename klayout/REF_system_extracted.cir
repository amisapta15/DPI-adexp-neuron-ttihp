* Extracted by KLayout with SG13G2 LVS runset on : 19/03/2026 02:50

.SUBCKT REF_system GND v_ref v_mem Vrefcap REQ VDD ACK
M$1 GND GND GND \$1 sg13_hv_nmos L=3u W=10u AS=2.65p AD=2.65p PS=19.24u
+ PD=19.24u
M$2 GND GND GND \$1 sg13_hv_nmos L=4u W=4u AS=0.76p AD=0.76p PS=7.04u PD=7.04u
M$8 GND v_ref \$4 \$1 sg13_hv_nmos L=4u W=16u AS=3.04p AD=3.04p PS=19.04u
+ PD=19.04u
M$25 \$4 REQ Vrefcap \$1 sg13_hv_nmos L=0.5u W=1u AS=0.34p AD=0.34p PS=2.68u
+ PD=2.68u
M$26 GND Vrefcap v_mem \$1 sg13_hv_nmos L=0.5u W=1u AS=0.34p AD=0.34p PS=2.68u
+ PD=2.68u
M$27 Vrefcap REQ \$30 \$26 sg13_hv_pmos L=0.5u W=1u AS=0.34p AD=0.19p PS=2.68u
+ PD=1.38u
M$28 \$30 ACK VDD \$26 sg13_hv_pmos L=0.5u W=1u AS=0.19p AD=0.34p PS=1.38u
+ PD=2.68u
R$29 \$26 VDD ntap1 A=18.24p P=121.6u
R$30 \$1 GND ptap1 A=20.46p P=136.4u
.ENDS REF_system
