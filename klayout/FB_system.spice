** sch_path: /foss/designs/adex_neuron/chenxi_working/ttihp26a-adex-neuron-ncs/xschem/FB_system.sch
.subckt FB_system VDD out V_mem GND nwell psub
*.PININFO out:O V_mem:B VDD:B GND:B nwell:B psub:B
Mmirr Vmir Vmir VDD nwell sg13_hv_pmos w=4u l=2u ng=4
Mmirl4 V_mem Vmir net1 nwell sg13_hv_pmos w=1u l=2u ng=1
Mthr out V_mem Vmir nwell sg13_hv_pmos w=4u l=2u ng=4
Mmem1 out V_mem net2 psub sg13_hv_nmos w=1u l=2u ng=1 m=2
Mmirl3 net1 Vmir net3 nwell sg13_hv_pmos w=1u l=2u ng=1
Mmirl2 net3 Vmir net4 nwell sg13_hv_pmos w=1u l=2u ng=1
Mmirl1 net4 Vmir VDD nwell sg13_hv_pmos w=1u l=2u ng=1
Mmem2 net2 V_mem net5 psub sg13_hv_nmos w=1u l=2u ng=1 m=2
Mmem3 net5 V_mem net6 psub sg13_hv_nmos w=1u l=2u ng=1 m=2
Mmem4 net6 V_mem GND psub sg13_hv_nmos w=1u l=2u ng=1 m=2
Mdum1 GND GND GND psub sg13_hv_nmos w=6u l=2u ng=6 m=2
Mdum2 GND GND GND psub sg13_hv_nmos w=1u l=2u ng=1 m=2
Mdum3 out GND GND psub sg13_hv_nmos w=1u l=2u ng=1 m=2
Mdum4 VDD VDD VDD nwell sg13_hv_pmos w=6u l=2u ng=6 m=2
Mdum5 VDD VDD VDD nwell sg13_hv_pmos w=1u l=2u ng=1 m=3
Mdum6 out VDD VDD nwell sg13_hv_pmos w=1u l=2u ng=1 m=2
Mdum7 V_mem VDD VDD nwell sg13_hv_pmos w=1u l=2u ng=1
R1 VDD nwell ntap1 A=1.554e-11 P=0.0001036
R2 GND psub ptap1 A=1.416e-11 P=9.44e-05
.ends
